** sch_path: /foss/designs/SAR_ADC_IHP/xschem/dac_icms_cell/testbenches/tb_unit_cell_logic_reg_tran_v2 - copia.sch
**.subckt tb_unit_cell_logic_reg_tran_v2 - copia
V1 vdd GND 1.8
V6 vcm GND 0.9
V8 vinp vcm 0.1
x13 VDD A GND net3 vinp A_n transmission_gate_lv_w_dummy W_P=W_P_TG L_P=L_P_TG W_N=W_N_TG L_N=L_N_TG W_P_D=1.0u L_P_D=0.13u
+ W_N_D=1.0u L_N_D=0.13u n=n
V9 vcm vinn 0
x15 VDD B GND net4 vcm b_n transmission_gate_lv_w_dummy W_P=W_P_TG L_P=L_P_TG W_N=W_N_TG L_N=L_N_TG W_P_D=1.0u L_P_D=0.13u
+ W_N_D=1.0u L_N_D=0.13u n=n
x16 VDD A GND net5 vcm A_n transmission_gate_lv_w_dummy W_P=W_P_TG L_P=L_P_TG W_N=W_N_TG L_N=L_N_TG W_P_D=1.0u L_P_D=0.13u
+ W_N_D=1.0u L_N_D=0.13u n=n
V3 start GND PULSE(0 1.8 0 10p 10p 2n 3n 1)
x21 VDD b_n_ctrl net6 GND inverter_lv W_P=1.0u L_P=0.13u W_N=1.0u L_N=0.13u n=1
x22 VDD net6 b_n GND inverter_lv W_P=10.0u L_P=0.13u W_N=10.0u L_N=0.13u n=1
x23 VDD b_ctrl net7 GND inverter_lv W_P=1.0u L_P=0.13u W_N=1.0u L_N=0.13u n=1
x24 VDD net7 B GND inverter_lv W_P=10.0u L_P=0.13u W_N=10.0u L_N=0.13u n=1
x25 VDD a_n_ctrl net8 GND inverter_lv W_P=1.0u L_P=0.13u W_N=1.0u L_N=0.13u n=1
x26 VDD net8 A_n GND inverter_lv W_P=20.0u L_P=0.13u W_N=10.0u L_N=0.13u n=1
x27 VDD a_ctrl net9 GND inverter_lv W_P=1.0u L_P=0.13u W_N=1.0u L_N=0.13u n=1
x28 VDD net9 A GND inverter_lv W_P=20.0u L_P=0.13u W_N=10.0u L_N=0.13u n=1
x29 start net2 VDD GND b_ctrl sg13g2_nor2_2
x30 net1 start VDD GND a_n_ctrl sg13g2_nand2_2
x31 b_ctrl VDD GND b_n_ctrl sg13g2_inv_2
x32 a_n_ctrl VDD GND a_ctrl sg13g2_inv_2
V5 VSS GND 0
x33 A_n net10 VDD GND net2 sg13g2_nand2_2
x34 B net11 VDD GND net1 sg13g2_nor2_2
x35 A VDD VSS net10 sg13g2_inv_1
x36 b_n VDD VSS net11 sg13g2_inv_1
V13 bot net4 0
V14 top net5 0
V18 bot net3 0
C3 top bot 20f m=64
**** begin user architecture code

.param temp=27
.param pon = 1
.param W_P = pon*1.0u
.param L_P = 0.13u
.param W_N = 1.0u
.param L_N = 0.13u
.param W_P_TG = pon*1.0u
.param L_P_TG = 0.13u
.param W_N_TG = 1.0u
.param L_N_TG = 0.13u
.param n = 64

*.options savecurrents klu method=gear reltol=1e-2 abstol=1e-15 gmin=1e-15
.control

* Transient Analysis
tran 1p 3n

plot a a_n b b_n start
plot bot-top start
plot bot top start

.endc

** IHP models
.lib cornerMOSlv.lib mos_tt
.lib cornerMOShv.lib mos_tt
.lib cornerHBT.lib hbt_typ
.lib cornerRES.lib res_typ
.include /foss/pdks/ihp-sg13g2/libs.ref/sg13g2_stdcell/spice/sg13g2_stdcell.spice

**** end user architecture code
**.ends

* expanding   symbol:  transmission_gate/transmission_gate_lv_w_dummy.sym # of pins=6
** sym_path: /foss/designs/SAR_ADC_IHP/xschem/transmission_gate/transmission_gate_lv_w_dummy.sym
** sch_path: /foss/designs/SAR_ADC_IHP/xschem/transmission_gate/transmission_gate_lv_w_dummy.sch
.subckt transmission_gate_lv_w_dummy VDD di_tg_ctrl VSS v_b v_a di_tg_ctrl_n  W_P=2.0u L_P=0.13u W_N=2.0u L_N=0.13u W_P_D=1.0u
+ L_P_D=0.13u W_N_D=1.0u L_N_D=0.13u n=1
*.iopin v_a
*.iopin v_b
*.iopin VDD
*.iopin VSS
*.ipin di_tg_ctrl
*.ipin di_tg_ctrl_n
XM1 net3 net4 net1 VSS sg13_lv_nmos w=W_N l=L_N ng=1 m=n
XM2 net2 net5 net1 VDD sg13_lv_pmos w=W_P l=L_P ng=1 m=n
XMdummy2 net1 net6 net1 VDD sg13_lv_pmos w=W_P l=L_P ng=1 m={n/2}
XMdummy1 net1 net7 net1 VSS sg13_lv_nmos w=W_N l=L_N ng=1 m={n/2}
Vig1 di_tg_ctrl net4 0
Vig2 di_tg_ctrl_n net5 0
Vig1d di_tg_ctrl_n net7 0
Vig2d di_tg_ctrl net6 0
Vid2 v_a net2 0
Vid1 v_a net3 0
Vis2 v_b net1 0
Vis1 v_b net1 0
.ends

* expanding   symbol:  inverter/inverter_lv.sym # of pins=4
** sym_path: /foss/designs/SAR_ADC_IHP/xschem/inverter/inverter_lv.sym
** sch_path: /foss/designs/SAR_ADC_IHP/xschem/inverter/inverter_lv.sch
.subckt inverter_lv VDD vin vout VSS  W_P=3.0u L_P=0.13u W_N=1.0u L_N=0.13u n=1
*.ipin vin
*.iopin VDD
*.iopin VSS
*.opin vout
XM1 vout vin VDD VDD sg13_lv_pmos w=W_P l=L_P ng=1 m=n
XM2 vout vin VSS VSS sg13_lv_nmos w=W_N l=L_N ng=1 m=n
.ends

.GLOBAL GND
.end
