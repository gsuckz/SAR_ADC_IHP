** sch_path: /foss/designs/SAR_ADC_IHP/xschem/dac_icms_cell/dac.sch
**.subckt dac vdacn vcm b9 b7 b0 b11 b3 b4 b2 b1 b8 b6 b5 b10 VSS VDD sample_pin vdacp vinp vinn D9 D7 D0 D11 D3 D4 D2 D1 D8 D6 D5
*+ D10
*.ipin D0
*.ipin b0
*.iopin vinp
*.iopin vcm
*.ipin sample_pin
*.iopin vinn
*.iopin vdacp
*.iopin vdacn
*.iopin VSS
*.iopin VDD
*.ipin D1
*.ipin b1
*.ipin D2
*.ipin b2
*.ipin D3
*.ipin b3
*.ipin D4
*.ipin b4
*.ipin D5
*.ipin b5
*.ipin D6
*.ipin b6
*.ipin D7
*.ipin b7
*.ipin D8
*.ipin b8
*.ipin D9
*.ipin b9
*.ipin D10
*.ipin b10
*.ipin D11
*.ipin b11
x14 VDD D0 VSS vdacn b0 vcm vinn a_sample a_sample_n b_sample b_sample_n unit_cell_n W_P_SPDT=1.0u L_P_SPDT=0.13u W_N_SPDT=1.0u
+ L_N_SPDT=0.13u Cu=20f n=32
x18 VDD D0 VSS vdacp b0 vcm vinp a_sample a_sample_n b_sample b_sample_n unit_cell W_P_SPDT=1.0u L_P_SPDT=0.13u W_N_SPDT=1.0u
+ L_N_SPDT=0.13u Cu=20f n=32
C1 vdacp2 vdacn 20f m=1
C4 vdacp2 vcm 20f m=1
x1 VDD D1 VSS vdacn b1 vcm vinn a_sample a_sample_n b_sample b_sample_n unit_cell_n W_P_SPDT=1.0u L_P_SPDT=0.13u W_N_SPDT=1.0u
+ L_N_SPDT=0.13u Cu=20f n=16
x2 VDD D2 VSS vdacn b2 vcm vinn a_sample a_sample_n b_sample b_sample_n unit_cell_n W_P_SPDT=1.0u L_P_SPDT=0.13u W_N_SPDT=1.0u
+ L_N_SPDT=0.13u Cu=20f n=8
x3 VDD D3 VSS vdacn b3 vcm vinn a_sample a_sample_n b_sample b_sample_n unit_cell_n W_P_SPDT=1.0u L_P_SPDT=0.13u W_N_SPDT=1.0u
+ L_N_SPDT=0.13u Cu=20f n=4
x4 VDD D4 VSS vdacn b4 vcm vinn a_sample a_sample_n b_sample b_sample_n unit_cell_n W_P_SPDT=1.0u L_P_SPDT=0.13u W_N_SPDT=1.0u
+ L_N_SPDT=0.13u Cu=20f n=2
x5 VDD D5 VSS vdacn b5 vcm vinn a_sample a_sample_n b_sample b_sample_n unit_cell_n W_P_SPDT=1.0u L_P_SPDT=0.13u W_N_SPDT=1.0u
+ L_N_SPDT=0.13u Cu=20f n=1
x6 VDD D6 VSS vdacp2 b6 vcm vinn a_sample a_sample_n b_sample b_sample_n unit_cell_n W_P_SPDT=1.0u L_P_SPDT=0.13u W_N_SPDT=1.0u
+ L_N_SPDT=0.13u Cu=20f n=32
x7 VDD D7 VSS vdacp2 b7 vcm vinn a_sample a_sample_n b_sample b_sample_n unit_cell_n W_P_SPDT=1.0u L_P_SPDT=0.13u W_N_SPDT=1.0u
+ L_N_SPDT=0.13u Cu=20f n=16
x8 VDD D8 VSS vdacp2 b8 vcm vinn a_sample a_sample_n b_sample b_sample_n unit_cell_n W_P_SPDT=1.0u L_P_SPDT=0.13u W_N_SPDT=1.0u
+ L_N_SPDT=0.13u Cu=20f n=8
x9 VDD D9 VSS vdacp2 b9 vcm vinn a_sample a_sample_n b_sample b_sample_n unit_cell_n W_P_SPDT=1.0u L_P_SPDT=0.13u W_N_SPDT=1.0u
+ L_N_SPDT=0.13u Cu=20f n=4
x11 VDD D10 VSS vdacp2 b10 vcm vinn a_sample a_sample_n b_sample b_sample_n unit_cell_n W_P_SPDT=1.0u L_P_SPDT=0.13u W_N_SPDT=1.0u
+ L_N_SPDT=0.13u Cu=20f n=2
x12 VDD D11 VSS vdacp2 b11 vcm vinn a_sample a_sample_n b_sample b_sample_n unit_cell_n W_P_SPDT=1.0u L_P_SPDT=0.13u W_N_SPDT=1.0u
+ L_N_SPDT=0.13u Cu=20f n=1
x13 VDD D1 VSS vdacp b1 vcm vinp a_sample a_sample_n b_sample b_sample_n unit_cell W_P_SPDT=1.0u L_P_SPDT=0.13u W_N_SPDT=1.0u
+ L_N_SPDT=0.13u Cu=20f n=16
x15 VDD D2 VSS vdacp b2 vcm vinp a_sample a_sample_n b_sample b_sample_n unit_cell W_P_SPDT=1.0u L_P_SPDT=0.13u W_N_SPDT=1.0u
+ L_N_SPDT=0.13u Cu=20f n=8
x16 VDD D3 VSS vdacp b3 vcm vinp a_sample a_sample_n b_sample b_sample_n unit_cell W_P_SPDT=1.0u L_P_SPDT=0.13u W_N_SPDT=1.0u
+ L_N_SPDT=0.13u Cu=20f n=4
x19 VDD D4 VSS vdacp b4 vcm vinp a_sample a_sample_n b_sample b_sample_n unit_cell W_P_SPDT=1.0u L_P_SPDT=0.13u W_N_SPDT=1.0u
+ L_N_SPDT=0.13u Cu=20f n=2
x20 VDD D5 VSS vdacp b5 vcm vinp a_sample a_sample_n b_sample b_sample_n unit_cell W_P_SPDT=1.0u L_P_SPDT=0.13u W_N_SPDT=1.0u
+ L_N_SPDT=0.13u Cu=20f n=1
C3 vdacn2 vdacp 20f m=1
x21 VDD D6 VSS vdacn2 b6 vcm vinp a_sample a_sample_n b_sample b_sample_n unit_cell W_P_SPDT=1.0u L_P_SPDT=0.13u W_N_SPDT=1.0u
+ L_N_SPDT=0.13u Cu=20f n=32
x22 VDD D7 VSS vdacn2 b7 vcm vinp a_sample a_sample_n b_sample b_sample_n unit_cell W_P_SPDT=1.0u L_P_SPDT=0.13u W_N_SPDT=1.0u
+ L_N_SPDT=0.13u Cu=20f n=16
x23 VDD D8 VSS vdacn2 b8 vcm vinp a_sample a_sample_n b_sample b_sample_n unit_cell W_P_SPDT=1.0u L_P_SPDT=0.13u W_N_SPDT=1.0u
+ L_N_SPDT=0.13u Cu=20f n=8
x24 VDD D9 VSS vdacn2 b9 vcm vinp a_sample a_sample_n b_sample b_sample_n unit_cell W_P_SPDT=1.0u L_P_SPDT=0.13u W_N_SPDT=1.0u
+ L_N_SPDT=0.13u Cu=20f n=4
x25 VDD D10 VSS vdacn2 b10 vcm vinp a_sample a_sample_n b_sample b_sample_n unit_cell W_P_SPDT=1.0u L_P_SPDT=0.13u W_N_SPDT=1.0u
+ L_N_SPDT=0.13u Cu=20f n=2
x26 VDD D11 VSS vdacn2 b11 vcm vinp a_sample a_sample_n b_sample b_sample_n unit_cell W_P_SPDT=1.0u L_P_SPDT=0.13u W_N_SPDT=1.0u
+ L_N_SPDT=0.13u Cu=20f n=1
C5 vcm vdacn2 20f m=1
x27 VDD b_n_ctrl net3 VSS inverter_lv W_P=1.0u L_P=0.13u W_N=1.0u L_N=0.13u n=1
x28 VDD net3 b_sample_n VSS inverter_lv W_P=10.0u L_P=0.13u W_N=10.0u L_N=0.13u n=1
x29 VDD b_ctrl net4 VSS inverter_lv W_P=1.0u L_P=0.13u W_N=1.0u L_N=0.13u n=1
x31 VDD net4 b_sample VSS inverter_lv W_P=10.0u L_P=0.13u W_N=10.0u L_N=0.13u n=1
x32 VDD a_n_ctrl net5 VSS inverter_lv W_P=1.0u L_P=0.13u W_N=1.0u L_N=0.13u n=1
x33 VDD net5 a_sample_n VSS inverter_lv W_P=20.0u L_P=0.13u W_N=10.0u L_N=0.13u n=1
x35 VDD a_ctrl net6 VSS inverter_lv W_P=1.0u L_P=0.13u W_N=1.0u L_N=0.13u n=1
x36 VDD net6 a_sample VSS inverter_lv W_P=20.0u L_P=0.13u W_N=10.0u L_N=0.13u n=1
x38 sample_pin net2 VDD VSS b_ctrl sg13g2_nor2_2
x39 net1 sample_pin VDD VSS a_n_ctrl sg13g2_nand2_2
x40 b_ctrl VDD VSS b_n_ctrl sg13g2_inv_2
x41 a_n_ctrl VDD VSS a_ctrl sg13g2_inv_2
x42 a_sample_n net7 VDD VSS net2 sg13g2_nand2_2
x43 b_sample net8 VDD VSS net1 sg13g2_nor2_2
x44 a_sample VDD VSS net7 sg13g2_inv_1
x45 b_sample_n VDD VSS net8 sg13g2_inv_1
**** begin user architecture code

.param ro = 500

**** end user architecture code
**.ends

* expanding   symbol:  dac_icms_cell/unit_cell_n.sym # of pins=11
** sym_path: /foss/designs/SAR_ADC_IHP/xschem/dac_icms_cell/unit_cell_n.sym
** sch_path: /foss/designs/SAR_ADC_IHP/xschem/dac_icms_cell/unit_cell_n.sch
.subckt unit_cell_n VDD d VSS v_top bit v_cm v_in a_sample a_sample_n b_sample b_sample_n  W_P_SPDT=1.0u L_P_SPDT=0.13u
+ W_N_SPDT=1.0u L_N_SPDT=0.13u Cu=8f n=1
*.iopin VSS
*.iopin v_in
*.ipin d
*.ipin bit
*.iopin v_top
*.iopin v_cm
*.ipin b_sample
*.ipin b_sample_n
*.ipin a_sample
*.ipin a_sample_n
*.iopin VDD
S1 net2 net3 d VSS SW1
C2 net1 v_top Cu m=n
S2 net3 net1 b_sample b_sample_n SW1
S3 v_in net1 b_sample_n b_sample SW1
S4 v_top v_cm a_sample a_sample_n SW1
S5 VDD net2 bit VSS SW1
S6 net2 VSS bitn VSS SW1
S7 net3 v_cm dn VSS SW1
x8 VDD bit bitn VSS inverter_lv W_P=W_P_SPDT L_P=L_P_SPDT W_N=W_N_SPDT L_N=L_N_SPDT n=n
x1 VDD d dn VSS inverter_lv W_P=W_P_SPDT L_P=L_P_SPDT W_N=W_N_SPDT L_N=L_N_SPDT n=n
.ends

* expanding   symbol:  dac_icms_cell/unit_cell.sym # of pins=11
** sym_path: /foss/designs/SAR_ADC_IHP/xschem/dac_icms_cell/unit_cell.sym
** sch_path: /foss/designs/SAR_ADC_IHP/xschem/dac_icms_cell/unit_cell.sch
.subckt unit_cell VDD d VSS v_top bit v_cm v_in a_sample a_sample_n b_sample b_sample_n  W_P_SPDT=1.0u L_P_SPDT=0.13u
+ W_N_SPDT=1.0u L_N_SPDT=0.13u Cu=8f n=1
*.iopin VSS
*.iopin v_in
*.ipin d
*.ipin bit
*.iopin v_top
*.iopin v_cm
*.ipin b_sample
*.ipin b_sample_n
*.ipin a_sample
*.ipin a_sample_n
*.iopin VDD
S7 net2 net3 d VSS SW1
C1 net1 v_top Cu m=n
S9 net3 net1 b_sample b_sample_n SW1
S10 v_in net1 b_sample_n b_sample SW1
S11 v_top v_cm a_sample a_sample_n SW1
S12 VSS net2 bit VSS SW1
S13 net2 VDD bitn VSS SW1
S14 net3 v_cm dn VSS SW1
x8 VDD bit bitn VSS inverter_lv W_P=W_P_SPDT L_P=L_P_SPDT W_N=W_N_SPDT L_N=L_N_SPDT n=n
x1 VDD d dn VSS inverter_lv W_P=W_P_SPDT L_P=L_P_SPDT W_N=W_N_SPDT L_N=L_N_SPDT n=n
.ends

* expanding   symbol:  inverter/inverter_lv.sym # of pins=4
** sym_path: /foss/designs/SAR_ADC_IHP/xschem/inverter/inverter_lv.sym
** sch_path: /foss/designs/SAR_ADC_IHP/xschem/inverter/inverter_lv.sch
.subckt inverter_lv VDD vin vout VSS  W_P=3.0u L_P=0.13u W_N=1.0u L_N=0.13u n=1
*.ipin vin
*.iopin VDD
*.iopin VSS
*.opin vout
XM1 vout vin VDD VDD sg13_lv_pmos w=W_P l=L_P ng=1 m=n
XM2 vout vin VSS VSS sg13_lv_nmos w=W_N l=L_N ng=1 m=n
.ends

**** begin user architecture code
.MODEL SW1 SW
+ VT=0.9 VH=0.01
+ RON=ro ROFF=10G
**** end user architecture code
.end
