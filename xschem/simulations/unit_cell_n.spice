** sch_path: /foss/designs/SAR_ADC_IHP/xschem/dac_icms_cell/unit_cell_n.sch
**.subckt unit_cell_n VDD d VSS v_top bit v_cm v_in a_sample a_sample_n b_sample b_sample_n
*.iopin VSS
*.iopin v_in
*.ipin d
*.ipin bit
*.iopin v_top
*.iopin v_cm
*.ipin b_sample
*.ipin b_sample_n
*.ipin a_sample
*.ipin a_sample_n
*.iopin VDD
S1 net2 net3 d VSS SW1
C2 net1 v_top cu m=2
S2 net3 net1 b_sample b_sample_n SW1
S3 v_in net1 b_sample_n b_sample SW1
S4 v_top v_cm a_sample a_sample_n SW1
S5 VDD net2 bit VSS SW1
S6 net2 VSS bitn VSS SW1
S7 net3 v_cm dn VSS SW1
x8 VDD bit bitn VSS inverter_lv W_P=1.0u L_P=0.13u W_N=1.0u L_N=0.13u n=2
x1 VDD d dn VSS inverter_lv W_P=1.0u L_P=0.13u W_N=1.0u L_N=0.13u n=2
**.ends

* expanding   symbol:  inverter/inverter_lv.sym # of pins=4
** sym_path: /foss/designs/SAR_ADC_IHP/xschem/inverter/inverter_lv.sym
** sch_path: /foss/designs/SAR_ADC_IHP/xschem/inverter/inverter_lv.sch
.subckt inverter_lv VDD vin vout VSS  W_P=3.0u L_P=0.13u W_N=1.0u L_N=0.13u n=1
*.ipin vin
*.iopin VDD
*.iopin VSS
*.opin vout
XM1 vout vin VDD VDD sg13_lv_pmos w=W_P l=L_P ng=1 m=n
XM2 vout vin VSS VSS sg13_lv_nmos w=W_N l=L_N ng=1 m=n
.ends

**** begin user architecture code
.MODEL SW1 SW
+ VT=0.9 VH=0.01
+ RON=0.01 ROFF=10G
**** end user architecture code
.end
