** sch_path: /foss/designs/SAR_ADC_IHP/xschem/bootstrap/tb_bootstrap_pulse.sch
**.subckt tb_bootstrap_pulse
V2 vin GND PULSE(0 1.8 2n 10p 10p 4n 8n)
V4 VDD GND 1.8
C1 vpump clk_n 200f m=1
C2 vpump2 clk 200f m=1
XM6 vgate clk_n2 vbootstrap vbootstrap sg13_hv_pmos w=5u l=0.4u ng=5 m=4
XM8 clk_n2 clk Y VSS sg13_hv_nmos w=5u l=0.45u ng=1 m=5
XM9 clk_n2 clk VDD VDD sg13_hv_pmos w=15u l=0.4u ng=5 m=5
XM10 clk_n2 vgate Y VSS sg13_hv_nmos w=5u l=0.45u ng=1 m=5
XM11 Y vgate vin VSS sg13_hv_nmos w=5u l=0.45u ng=10 m=4
C3 vbootstrap Y 40f m=64
XM12 Y clk_n VSS VSS sg13_hv_nmos w=10u l=0.45u ng=1 m=2
XM13 vgate VDD vgate_ground VSS sg13_hv_nmos w=7u l=0.45u ng=2 m=4
XM3 vgate_ground clk_n VSS VSS sg13_hv_nmos w=7u l=0.45u ng=2 m=4
XM4 VDD vpump2 vpump VSS sg13_hv_nmos w=10u l=0.45u ng=1 m=1
XM5 VDD vpump vpump2 VSS sg13_hv_nmos w=10u l=0.45u ng=1 m=1
XM1 vc vgate vin VSS sg13_hv_nmos w=1u l=0.45u ng=2 m=64
V1 clk_n GND PULSE( 1.8 0 {delay_n} {rise_t} {fall_t} {ts} {period} )
V5 clk GND PULSE( 0 1.8 {delay_n} {rise_t} {fall_t} {ts} {period} )
C4 vc GND 20f m=64
V3 VSS GND 0
XM2 VDD vpump vbootstrap VSS sg13_hv_nmos w=10u l=0.45u ng=1 m=2
**** begin user architecture code

.param temp=27
.param ts=1n
.param period = 3*ts
.param wp = 1.5u
.param a = 1.8
.param wn = 0.5u
.param rise_t = period*0.01
.param fall_t = period*0.01
.param delay_n = 0
.param delay_s = 0
.param delay_2 = 0
.param delay_1 = 0
.options savecurrents klu method=gear reltol=1e-2 abstol=1e-15 gmin=1e-10
.control

* Transient Analysis
tran 1p 20n

plot clk clk_n vpump vpump2
plot vin vgate vc
plot vbootstrap vgate_ground  vgate Y clk clk_n clk_n2
.endc

** IHP models
.lib cornerMOSlv.lib mos_tt
.lib cornerMOShv.lib mos_tt
.lib cornerHBT.lib hbt_typ
.lib cornerRES.lib res_typ
.include /foss/pdks/ihp-sg13g2/libs.ref/sg13g2_stdcell/spice/sg13g2_stdcell.spice

**** end user architecture code
**.ends
.GLOBAL GND
.end
