** sch_path: /foss/designs/SAR_ADC_IHP/xschem/dac_icms_cell/testbenches/tb_capacitor.sch
**.subckt tb_capacitor
V7 sample_s GND PULSE( 0 1.8 {delay_1 + delay_s} {rise_t} {fall_t} {a*period/2} {a*period} 1)
V2 vin GND 1.7
V3 vcm GND 0.9
V4 VDD GND 1.8
C1 vcbot vctop 20f m=64
V1 vcbot net1 0
V5 vcbot net2 0
XM1 vin sample_s net2 GND sg13_lv_nmos w={wn} l=0.13u ng=1 m=64
XM2 vin sample_n net1 VDD sg13_lv_pmos w={wp} l=0.13u ng=1 m=64
XM3 net2 sample_n net2 GND sg13_lv_nmos w={wn} l=0.13u ng=1 m=32
XM4 net1 sample_s net1 VDD sg13_lv_pmos w={wp} l=0.13u ng=1 m=32
V10 vctop net3 0
V11 vctop net4 0
XM7 vcm sample_s2 net4 GND sg13_lv_nmos w={wn} l=0.13u ng=1 m=64
XM8 vcm sample_n2 net3 VDD sg13_lv_pmos w={wp} l=0.13u ng=1 m=64
XM9 net4 sample_n2 net4 GND sg13_lv_nmos w={wn} l=0.13u ng=1 m=32
XM10 net3 sample_s2 net3 VDD sg13_lv_pmos w={wp} l=0.13u ng=1 m=32
V8 sample_s2 GND PULSE( 0 1.8 {delay_2 + delay_s} {rise_t} {fall_t} {period/2} {period} 1)
V9 sample_n GND PULSE( 1.8 0 {delay_n} {rise_t} {fall_t} {a*period/2} {a*period} 1)
V12 sample_n2 GND PULSE( 1.8 0 {delay_n + delay_2} {rise_t} {fall_t} {period/2} {period} 1)
**** begin user architecture code

.param temp=27
.param period = 1.5n
.param wp = 1.5u
.param a = 1.8
.param wn = 0.5u
.param rise_t = period*0.1
.param fall_t = period*0.1
.param delay_n = 0
.param delay_s = 10p
.param delay_2 = period*0.2
.param delay_1 = 0
.options savecurrents klu method=gear reltol=1e-2 abstol=1e-15 gmin=1e-10
.control

* Transient Analysis
tran 1p 2n

*plot {d0} {d1 + 4} {d2 + 8} {d3 + 12} {d4 + 16} {d5 + 20} {d6 + 24} {d7 + 28} {d8 + 32} {d9 + 36} {d10 + 40} {d11 + 44}
*plot {b0} {b1 + 4} {b2 + 8} {b3 + 12} {b4 + 16} {b5 + 20} {b6 + 24} {b7 + 28} {b8 + 32} {b9 + 36} {b10 + 40} {b11 + 44}
*plot {clk} {comp_in + 2} {sample + 4}
plot vctop vcbot sample_s
plot {vctop-vcbot} sample_s
plot i(v1) i(v5)
*plot x3.x14.net1-vctop x3.x18.vcap-vcbot
plot sample_s sample_n sample_s2+2 sample_n2+2
.endc

** IHP models
.lib cornerMOSlv.lib mos_tt
.lib cornerMOShv.lib mos_tt
.lib cornerHBT.lib hbt_typ
.lib cornerRES.lib res_typ
.include /foss/pdks/ihp-sg13g2/libs.ref/sg13g2_stdcell/spice/sg13g2_stdcell.spice

**** end user architecture code
**.ends
.GLOBAL GND
.end
