** sch_path: /foss/designs/SAR_ADC_IHP/xschem/transmission_gate/testbenches/transmission_gate_tb_tran.sch
**.subckt transmission_gate_tb_tran
VDD VDD GND 1.5
vin vin_tg GND sin(0.75 0.75 1meg)
C1 vout_tg_lv_on GND 5p m=1
C2 vout_tg_lv_off GND 5p m=1
C3 vout_tg_hv_on GND 5p m=1
C4 vout_tg_hv_off GND 5p m=1
x1 VDD VDD GND vout_tg_hv_on vin_tg GND transmission_gate_hv_wo_dummy W_P={W_P} L_P={L_P} W_N={W_N} L_N={L_N}
x2 VDD VDD GND vout_tg_lv_on vin_tg GND transmission_gate_lv_wo_dummy W_P={W_P} L_P={L_P} W_N={W_N} L_N={L_N}
x3 VDD GND GND vout_tg_hv_off vin_tg VDD transmission_gate_hv_wo_dummy W_P={W_P} L_P={L_P} W_N={W_N} L_N={L_N}
x4 VDD GND GND vout_tg_lv_off vin_tg VDD transmission_gate_lv_wo_dummy W_P={W_P} L_P={L_P} W_N={W_N} L_N={L_N}
**** begin user architecture code

.lib cornerMOShv.lib mos_tt
.lib cornerMOSlv.lib mos_tt
.lib cornerRES.lib res_typ

.param temp=27
.param W_N=0.15u
.param L_N=0.5u
.param W_P=0.15u
.param L_P=0.5u
.options savecurrents
.control

save all

* Operating Point Analysis
op
remzerovec
write transmission_gate_tb_tran.raw
set appendwrite

* Transient Analysis
tran 1n 10u
write transmission_gate_tb_tran.raw

plot vin_tg vout_tg_lv_on vout_tg_hv_on
plot vin_tg vout_tg_lv_off vout_tg_hv_off

* Writing Data
set wr_singlescale
set wr_vecnames
wrdata /foss/designs/SG13G2_ATBS-ADC-main/python/plot_simulations/data/transmission_gate_tb_tran.txt v(vin_tg) v(vout_tg_lv_on) v(vout_tg_hv_on) v(vout_tg_lv_off) v(vout_tg_hv_off)

*quit
.endc

**** end user architecture code
**.ends

* expanding   symbol:  transmission_gate/transmission_gate_hv_wo_dummy.sym # of pins=6
** sym_path: /foss/designs/SAR_ADC_IHP/xschem/transmission_gate/transmission_gate_hv_wo_dummy.sym
** sch_path: /foss/designs/SAR_ADC_IHP/xschem/transmission_gate/transmission_gate_hv_wo_dummy.sch
.subckt transmission_gate_hv_wo_dummy VDD di_tg_ctrl VSS v_b v_a di_tg_ctrl_n  W_P=1.0u L_P=0.5u W_N=1.0u L_N=0.5u
*.iopin v_a
*.iopin v_b
*.iopin VDD
*.iopin VSS
*.ipin di_tg_ctrl
*.ipin di_tg_ctrl_n
XM1 v_a di_tg_ctrl v_b VSS sg13_hv_nmos w=W_N l=L_N ng=1 m=1
XM2 v_a di_tg_ctrl_n v_b VDD sg13_hv_pmos w=W_P l=L_P ng=1 m=1
.ends

* expanding   symbol:  transmission_gate/transmission_gate_lv_wo_dummy.sym # of pins=6
** sym_path: /foss/designs/SAR_ADC_IHP/xschem/transmission_gate/transmission_gate_lv_wo_dummy.sym
** sch_path: /foss/designs/SAR_ADC_IHP/xschem/transmission_gate/transmission_gate_lv_wo_dummy.sch
.subckt transmission_gate_lv_wo_dummy VDD di_tg_ctrl VSS v_b v_a di_tg_ctrl_n  W_P=1.0u L_P=0.13u W_N=1.0u L_N=0.13u
*.iopin v_a
*.iopin v_b
*.iopin VDD
*.iopin VSS
*.ipin di_tg_ctrl
*.ipin di_tg_ctrl_n
XM1 v_a di_tg_ctrl v_b VSS sg13_lv_nmos w=W_N l=L_N ng=1 m=1
XM2 v_a di_tg_ctrl_n v_b VDD sg13_lv_pmos w=W_P l=L_P ng=1 m=1
.ends

.GLOBAL GND
.GLOBAL VDD
.end
