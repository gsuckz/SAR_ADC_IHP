** sch_path: /foss/designs/SAR_ADC_IHP/xschem/SAR_ADC/testbench/tb_sar_adc_param.sch
**.subckt tb_sar_adc_param
x1 vinp rst GND vinn GND vdd compn compp compout eoc d9 d7 d0 d11 d3 d4 d2 d1 d8 d6 d5 d10 sar
VI vinn net1 {vdiff/2}
V1 vdd GND 1.8
VIN2 net1 GND 0.9
VIN3 net1 vinp {vdiff/2}
V2 rst GND PULSE(0 1.8 0 10p 10p 5n 6n 1)
**** begin user architecture code

.param POINT = 100
.param vcm = 0.9
.param step = 439u
.param vdiff = {step*POINT}
.param period=5n
.param stoptime={18*period}
.param ro = 300

.options savecurrents klu method=gear reltol=1e-2 abstol=1e-15 gmin=1e-15

.tran {0.01*period} {stoptime}

.control
    * Configurar para modo batch
    set hcopydevtype=postscript

    * Ejecutar la simulación
    run

    * Buscar el momento cuando eoc cruza 1.8V
    let eoc_threshold = 1.8
    let time_vec = time
    let eoc_vec = v(eoc)

    * Encontrar el índice donde eoc supera el umbral
    let idx = 0
    let found = 0

    * Buscar el primer cruce ascendente
    while idx < (length(eoc_vec) - 1)
        if (eoc_vec[idx] < eoc_threshold) & (eoc_vec[idx+1] >= eoc_threshold)
            let found = 1
            let crossing_idx = idx + 1
            break
        end
        let idx = idx + 1
    end

    * Si se encontró el cruce, imprimir valores
    if found = 1
        echo EOC alcanzó 1.8V en t = $&time_vec[crossing_idx] s
        echo
        echo Valores de las señales digitales:
        echo =================================

        * Guardar en archivo
        echo PUNTO = $POINT > results/results_100.txt
        echo Tiempo (s): $&time_vec[crossing_idx] >> results/results_100.txt
        echo >> results/results_100.txt
        echo Señal - Voltaje (V) >> results/results_100.txt
        echo ------------------ >> results/results_100.txt

        * Imprimir valores en consola y archivo
        echo d0  = $&v(d0)[crossing_idx] V | tee -a results/results_100.txt
        echo d1  = $&v(d1)[crossing_idx] V | tee -a results/results_100.txt
        echo d2  = $&v(d2)[crossing_idx] V | tee -a results/results_100.txt
        echo d3  = $&v(d3)[crossing_idx] V | tee -a results/results_100.txt
        echo d4  = $&v(d4)[crossing_idx] V | tee -a results/results_100.txt
        echo d5  = $&v(d5)[crossing_idx] V | tee -a results/results_100.txt
        echo d6  = $&v(d6)[crossing_idx] V | tee -a results/results_100.txt
        echo d7  = $&v(d7)[crossing_idx] V | tee -a results/results_100.txt
        echo d8  = $&v(d8)[crossing_idx] V | tee -a results/results_100.txt
        echo d9  = $&v(d9)[crossing_idx] V | tee -a results/results_100.txt
        echo d10 = $&v(d10)[crossing_idx] V | tee -a results/results_100.txt
        echo d11 = $&v(d11)[crossing_idx] V | tee -a results/results_100.txt
        echo
        echo Resultados guardados en results.txt
    else
        echo ERROR: EOC no alcanzó 1.8V durante la simulación
        echo Valor máximo de EOC: $&maximum(eoc_vec) V
    end

    quit
.endc

** IHP models
.lib cornerMOSlv.lib mos_tt
.lib cornerMOShv.lib mos_tt
.lib cornerHBT.lib hbt_typ
.lib cornerRES.lib res_typ
.lib cornerCAP.lib cap_typ
.include /foss/pdks/ihp-sg13g2/libs.ref/sg13g2_stdcell/spice/sg13g2_stdcell.spice

**** end user architecture code
**.ends

* expanding   symbol:  SAR_ADC/sar.sym # of pins=22
** sym_path: /foss/designs/SAR_ADC_IHP/xschem/SAR_ADC/sar.sym
** sch_path: /foss/designs/SAR_ADC_IHP/xschem/SAR_ADC/sar.sch
.subckt sar vinp rst clk vinn VSS VDD compn compp compout eoc b9 b7 b0 b11 b3 b4 b2 b1 b8 b6 b5 b10
*.ipin vinp
*.iopin VDD
*.opin b11
*.ipin vinn
*.ipin clk
*.iopin VSS
*.opin b10
*.opin b9
*.opin b8
*.opin b7
*.opin b6
*.opin b5
*.opin b4
*.opin b3
*.opin b2
*.opin b1
*.opin b0
*.opin compp
*.opin compn
*.opin compout
*.opin eoc
*.ipin rst
x1 VDD compp compout compn net1 VSS comp_clk DT_comparator
x2 compn vcm b9 b7 b0 b11 b3 b4 b2 b1 b8 b6 b5 b10 VSS VDD sample compp vinp vinn d9 d7 d0 d11 d3 d4 d2 d1 d8 d6 d5 d10 dac cu=10
x3 b9 b7 b0 b11 b3 b4 b2 b1 b8 b6 b5 b10 VSS VDD sample d9 d7 d0 d11 d3 d4 d2 d1 d8 d6 d5 d10 compout comp_clk rst eoc logic
V1 vcm VSS 0.9
x6 net1 net2 VDD VSS sg13g2_inv_2
x4 net2 rst VDD VSS sg13g2_dlygate4sd1_1
.ends

* expanding   symbol:  comparator/discrete_time/DT_comparator.sym # of pins=7
** sym_path: /foss/designs/SAR_ADC_IHP/xschem/comparator/discrete_time/DT_comparator.sym
** sch_path: /foss/designs/SAR_ADC_IHP/xschem/comparator/discrete_time/DT_comparator.sch
.subckt DT_comparator VDD vinp vout vinn en VSS PULSE
*.iopin VDD
*.opin vout
*.iopin VSS
*.ipin vinp
*.ipin vinn
*.ipin en
*.iopin PULSE
x2 VDD voutp_comp voutp_buf VSS buffer_lv W_P_INV=1.0u L_P_INV=0.13u W_N_INV=1.0u L_N_INV=0.13u
x3 VDD voutn_comp voutn_buf VSS buffer_lv W_P_INV=1.0u L_P_INV=0.13u W_N_INV=1.0u L_N_INV=0.13u
x5 VDD PULSEN PULSE VSS inverter_lv W_P=2.0u L_P=0.13u W_N=2.0u L_N=0.13u n=1
* noconn #net1
x4 VDD voutp_buf net1 VSS net3 voutn_buf SR_latch W_P_SR=1.0u L_P_SR=0.13u W_N_SR=1.0u L_N_SR=0.13u
x6 VDD voutp_buf VSS voutn_buf PULSEN net2 en pgen
V1 VDD net2 0.7
x1 PULSE PULSEN VDD voutp_comp vinp VSS voutn_comp vinn dynamic_biasing_comparator
x7 VDD net3 vout VSS buffer_lv W_P_INV=3.0u L_P_INV=0.13u W_N_INV=3.0u L_N_INV=0.13u
.ends

* expanding   symbol:  dac_icms_cell/dac.sym # of pins=32
** sym_path: /foss/designs/SAR_ADC_IHP/xschem/dac_icms_cell/dac.sym
** sch_path: /foss/designs/SAR_ADC_IHP/xschem/dac_icms_cell/dac.sch
.subckt dac vdacn vcm b9 b7 b0 b11 b3 b4 b2 b1 b8 b6 b5 b10 VSS VDD sample_pin vdacp vinp vinn D9 D7 D0 D11 D3 D4 D2 D1 D8 D6 D5
+ D10  cu=5u
*.ipin D0
*.ipin b0
*.iopin vinp
*.iopin vcm
*.ipin sample_pin
*.iopin vinn
*.iopin vdacp
*.iopin vdacn
*.iopin VSS
*.iopin VDD
*.ipin D1
*.ipin b1
*.ipin D2
*.ipin b2
*.ipin D3
*.ipin b3
*.ipin D4
*.ipin b4
*.ipin D5
*.ipin b5
*.ipin D6
*.ipin b6
*.ipin D7
*.ipin b7
*.ipin D8
*.ipin b8
*.ipin D9
*.ipin b9
*.ipin D10
*.ipin b10
*.ipin D11
*.ipin b11
x14 VDD D0 VSS vdacn b0 vcm vinn a_sample a_sample_n b_sample b_sample_n unit_cell_n W_P_SPDT=1.0u L_P_SPDT=0.13u W_N_SPDT=1.0u
+ L_N_SPDT=0.13u Cu=cu n=32
x18 VDD D0 VSS vdacp b0 vcm vinp a_sample_n a_sample b_sample b_sample_n unit_cell W_P_SPDT=1.0u L_P_SPDT=0.13u W_N_SPDT=1.0u
+ L_N_SPDT=0.13u Cu=cu n=32
x1 VDD D1 VSS vdacn b1 vcm vinn a_sample a_sample_n b_sample b_sample_n unit_cell_n W_P_SPDT=1.0u L_P_SPDT=0.13u W_N_SPDT=1.0u
+ L_N_SPDT=0.13u Cu=cu n=16
x2 VDD D2 VSS vdacn b2 vcm vinn a_sample a_sample_n b_sample b_sample_n unit_cell_n W_P_SPDT=1.0u L_P_SPDT=0.13u W_N_SPDT=1.0u
+ L_N_SPDT=0.13u Cu=cu n=8
x3 VDD D3 VSS vdacn b3 vcm vinn a_sample a_sample_n b_sample b_sample_n unit_cell_n W_P_SPDT=1.0u L_P_SPDT=0.13u W_N_SPDT=1.0u
+ L_N_SPDT=0.13u Cu=cu n=4
x4 VDD D4 VSS vdacn b4 vcm vinn a_sample a_sample_n b_sample b_sample_n unit_cell_n W_P_SPDT=1.0u L_P_SPDT=0.13u W_N_SPDT=1.0u
+ L_N_SPDT=0.13u Cu=cu n=2
x5 VDD D5 VSS vdacn b5 vcm vinn a_sample a_sample_n b_sample b_sample_n unit_cell_n W_P_SPDT=1.0u L_P_SPDT=0.13u W_N_SPDT=1.0u
+ L_N_SPDT=0.13u Cu=cu n=1
x6 VDD D6 VSS vdacp2 b6 vcm vinn a_sample a_sample_n b_sample b_sample_n unit_cell_n W_P_SPDT=1.0u L_P_SPDT=0.13u W_N_SPDT=1.0u
+ L_N_SPDT=0.13u Cu=cu n=32
x7 VDD D7 VSS vdacp2 b7 vcm vinn a_sample a_sample_n b_sample b_sample_n unit_cell_n W_P_SPDT=1.0u L_P_SPDT=0.13u W_N_SPDT=1.0u
+ L_N_SPDT=0.13u Cu=cu n=16
x8 VDD D8 VSS vdacp2 b8 vcm vinn a_sample a_sample_n b_sample b_sample_n unit_cell_n W_P_SPDT=1.0u L_P_SPDT=0.13u W_N_SPDT=1.0u
+ L_N_SPDT=0.13u Cu=cu n=8
x9 VDD D9 VSS vdacp2 b9 vcm vinn a_sample a_sample_n b_sample b_sample_n unit_cell_n W_P_SPDT=1.0u L_P_SPDT=0.13u W_N_SPDT=1.0u
+ L_N_SPDT=0.13u Cu=cu n=4
x11 VDD D10 VSS vdacp2 b10 vcm vinn a_sample a_sample_n b_sample b_sample_n unit_cell_n W_P_SPDT=1.0u L_P_SPDT=0.13u W_N_SPDT=1.0u
+ L_N_SPDT=0.13u Cu=cu n=2
x12 VDD D11 VSS vdacp2 b11 vcm vinn a_sample a_sample_n b_sample b_sample_n unit_cell_n W_P_SPDT=1.0u L_P_SPDT=0.13u W_N_SPDT=1.0u
+ L_N_SPDT=0.13u Cu=cu n=1
x13 VDD D1 VSS vdacp b1 vcm vinp a_sample_n a_sample b_sample b_sample_n unit_cell W_P_SPDT=1.0u L_P_SPDT=0.13u W_N_SPDT=1.0u
+ L_N_SPDT=0.13u Cu=cu n=16
x15 VDD D2 VSS vdacp b2 vcm vinp a_sample_n a_sample b_sample b_sample_n unit_cell W_P_SPDT=1.0u L_P_SPDT=0.13u W_N_SPDT=1.0u
+ L_N_SPDT=0.13u Cu=cu n=8
x16 VDD D3 VSS vdacp b3 vcm vinp a_sample_n a_sample b_sample b_sample_n unit_cell W_P_SPDT=1.0u L_P_SPDT=0.13u W_N_SPDT=1.0u
+ L_N_SPDT=0.13u Cu=cu n=4
x19 VDD D4 VSS vdacp b4 vcm vinp a_sample_n a_sample b_sample b_sample_n unit_cell W_P_SPDT=1.0u L_P_SPDT=0.13u W_N_SPDT=1.0u
+ L_N_SPDT=0.13u Cu=cu n=2
x20 VDD D5 VSS vdacp b5 vcm vinp a_sample_n a_sample b_sample b_sample_n unit_cell W_P_SPDT=1.0u L_P_SPDT=0.13u W_N_SPDT=1.0u
+ L_N_SPDT=0.13u Cu=cu n=1
x21 VDD D6 VSS vdacn2 b6 vcm vinp a_sample_n a_sample b_sample b_sample_n unit_cell W_P_SPDT=1.0u L_P_SPDT=0.13u W_N_SPDT=1.0u
+ L_N_SPDT=0.13u Cu=cu n=32
x22 VDD D7 VSS vdacn2 b7 vcm vinp a_sample_n a_sample b_sample b_sample_n unit_cell W_P_SPDT=1.0u L_P_SPDT=0.13u W_N_SPDT=1.0u
+ L_N_SPDT=0.13u Cu=cu n=16
x23 VDD D8 VSS vdacn2 b8 vcm vinp a_sample_n a_sample b_sample b_sample_n unit_cell W_P_SPDT=1.0u L_P_SPDT=0.13u W_N_SPDT=1.0u
+ L_N_SPDT=0.13u Cu=cu n=8
x24 VDD D9 VSS vdacn2 b9 vcm vinp a_sample_n a_sample b_sample b_sample_n unit_cell W_P_SPDT=1.0u L_P_SPDT=0.13u W_N_SPDT=1.0u
+ L_N_SPDT=0.13u Cu=cu n=4
x25 VDD D10 VSS vdacn2 b10 vcm vinp a_sample_n a_sample b_sample b_sample_n unit_cell W_P_SPDT=1.0u L_P_SPDT=0.13u W_N_SPDT=1.0u
+ L_N_SPDT=0.13u Cu=cu n=2
x26 VDD D11 VSS vdacn2 b11 vcm vinp a_sample_n a_sample b_sample b_sample_n unit_cell W_P_SPDT=1.0u L_P_SPDT=0.13u W_N_SPDT=1.0u
+ L_N_SPDT=0.13u Cu=cu n=1
x27 VDD b_n_ctrl net3 VSS inverter_lv W_P=1.0u L_P=0.13u W_N=1.0u L_N=0.13u n=1
x28 VDD net3 b_sample_n VSS inverter_lv W_P=10.0u L_P=0.13u W_N=10.0u L_N=0.13u n=1
x29 VDD b_ctrl net4 VSS inverter_lv W_P=1.0u L_P=0.13u W_N=1.0u L_N=0.13u n=1
x31 VDD net4 b_sample VSS inverter_lv W_P=10.0u L_P=0.13u W_N=10.0u L_N=0.13u n=1
x32 VDD a_n_ctrl net5 VSS inverter_lv W_P=1.0u L_P=0.13u W_N=1.0u L_N=0.13u n=1
x33 VDD net5 a_sample_n VSS inverter_lv W_P=20.0u L_P=0.13u W_N=10.0u L_N=0.13u n=1
x35 VDD a_ctrl net6 VSS inverter_lv W_P=1.0u L_P=0.13u W_N=1.0u L_N=0.13u n=1
x36 VDD net6 a_sample VSS inverter_lv W_P=20.0u L_P=0.13u W_N=10.0u L_N=0.13u n=1
x38 b_ctrl sample_pin net2 VDD VSS sg13g2_nor2_2
x39 a_n_ctrl net1 sample_pin VDD VSS sg13g2_nand2_2
x40 b_n_ctrl b_ctrl VDD VSS sg13g2_inv_2
x41 a_ctrl a_n_ctrl VDD VSS sg13g2_inv_2
x42 net2 a_sample_n net7 VDD VSS sg13g2_nand2_2
x43 net1 b_sample net8 VDD VSS sg13g2_nor2_2
x44 net7 a_sample VDD VSS sg13g2_inv_1
x45 net8 b_sample_n VDD VSS sg13g2_inv_1
XC1 vdacp vdacn2 cap_cmim w=2.6e-6 l=2.6e-6 m=1
XC2 vdacn vdacp2 cap_cmim w=2.6e-6 l=2.6e-6 m=1
XC3 vcm vdacp2 cap_cmim w=2.6e-6 l=2.6e-6 m=1
XC4 vcm vdacn2 cap_cmim w=2.6e-6 l=2.6e-6 m=1
.ends

* expanding   symbol:  logic/logic.sym # of pins=31
** sym_path: /foss/designs/SAR_ADC_IHP/xschem/logic/logic.sym
** sch_path: /foss/designs/SAR_ADC_IHP/xschem/logic/logic.sch
.subckt logic b9 b7 b0 b11 b3 b4 b2 b1 b8 b6 b5 b10 VSS VDD sample d9 d7 d0 d11 d3 d4 d2 d1 d8 d6 d5 d10 comp_in clk rst_pin eoc
*.iopin VDD
*.iopin VSS
*.ipin clk
*.ipin comp_in
*.opin b0
*.opin d0
*.opin b1
*.opin d1
*.opin b2
*.opin d2
*.opin b3
*.opin d3
*.opin b4
*.opin d4
*.opin b5
*.opin d5
*.opin b6
*.opin d6
*.opin b7
*.opin d7
*.opin b8
*.opin d8
*.opin b9
*.opin d9
*.opin b10
*.opin d10
*.opin b11
*.opin d11
*.ipin rst_pin
*.opin eoc
*.opin sample
x1 clk net1 rst comp_in VDD b0 VSS d0 bit_cell
x14 clk d0 rst comp_in VDD b1 VSS d1 bit_cell
x15 clk d1 rst comp_in VDD b2 VSS d2 bit_cell
x16 clk d2 rst comp_in VDD b3 VSS d3 bit_cell
x17 clk d3 rst comp_in VDD b4 VSS d4 bit_cell
x18 clk d4 rst comp_in VDD b5 VSS d5 bit_cell
x19 clk d5 rst comp_in VDD b6 VSS d6 bit_cell
x20 clk d6 rst comp_in VDD b7 VSS d7 bit_cell
x21 clk d7 rst comp_in VDD b8 VSS d8 bit_cell
x22 clk d8 rst comp_in VDD b9 VSS d9 bit_cell
x23 clk d9 rst comp_in VDD b10 VSS d10 bit_cell
x24 clk d10 rst comp_in VDD b11 VSS d11 bit_cell
x4 clk d11 rst VDD VDD net2 VSS eoc bit_cell
x6 VDD rst_pin net3 VSS buffer_lv W_P_INV=3.0u L_P_INV=0.13u W_N_INV=1.0u L_N_INV=0.13u
x7 VDD net3 sample VSS buffer_lv W_P_INV=10.0u L_P_INV=0.13u W_N_INV=10.0u L_N_INV=0.13u
x30 rst rst_pin VDD VSS sg13g2_inv_2
x3 clk VDD rst comp_in VDD net4 VSS net1 bit_cell
.ends

* expanding   symbol:  buffer/buffer_lv.sym # of pins=4
** sym_path: /foss/designs/SAR_ADC_IHP/xschem/buffer/buffer_lv.sym
** sch_path: /foss/designs/SAR_ADC_IHP/xschem/buffer/buffer_lv.sch
.subckt buffer_lv VDD vin vout VSS  W_P_INV=3.0u L_P_INV=0.13u W_N_INV=1.0u L_N_INV=0.13u
*.ipin vin
*.iopin VDD
*.iopin VSS
*.opin vout
x1 VDD vin net1 VSS inverter_lv W_P=W_P_INV L_P=L_P_INV W_N=W_N_INV L_N=L_N_INV n=1
x2 VDD net1 vout VSS inverter_lv W_P=W_P_INV L_P=L_P_INV W_N=W_N_INV L_N=L_N_INV n=1
.ends

* expanding   symbol:  inverter/inverter_lv.sym # of pins=4
** sym_path: /foss/designs/SAR_ADC_IHP/xschem/inverter/inverter_lv.sym
** sch_path: /foss/designs/SAR_ADC_IHP/xschem/inverter/inverter_lv.sch
.subckt inverter_lv VDD vin vout VSS  W_P=3.0u L_P=0.13u W_N=1.0u L_N=0.13u n=1
*.ipin vin
*.iopin VDD
*.iopin VSS
*.opin vout
XM1 vout vin VDD VDD sg13_lv_pmos w=W_P l=L_P ng=1 m=n
XM2 vout vin VSS VSS sg13_lv_nmos w=W_N l=L_N ng=1 m=n
.ends

* expanding   symbol:  comparator/SR_latch/SR_latch.sym # of pins=6
** sym_path: /foss/designs/SAR_ADC_IHP/xschem/comparator/SR_latch/SR_latch.sym
** sch_path: /foss/designs/SAR_ADC_IHP/xschem/comparator/SR_latch/SR_latch.sch
.subckt SR_latch VDD S Qn VSS Q R  W_P_SR=1.0u L_P_SR=0.13u W_N_SR=1.0u L_N_SR=0.13u
*.iopin VDD
*.opin Q
*.iopin VSS
*.ipin S
*.ipin R
*.opin Qn
x1 VDD Q R Qn VSS NOR_gate W_P=W_P_SR L_P=L_P_SR W_N=W_N_SR L_N=L_N_SR
x2 VDD Qn Q S VSS NOR_gate W_P=W_P_SR L_P=L_P_SR W_N=W_N_SR L_N=L_N_SR
.ends

* expanding   symbol:  comparator/pulse_gen/pgen.sym # of pins=7
** sym_path: /foss/designs/SAR_ADC_IHP/xschem/comparator/pulse_gen/pgen.sym
** sch_path: /foss/designs/SAR_ADC_IHP/xschem/comparator/pulse_gen/pgen.sch
.subckt pgen VDD in2 VSS in1 PULSE_n VTUNE en
*.iopin VDD
*.iopin in2
*.iopin in1
*.iopin VSS
*.iopin VTUNE
*.iopin PULSE_n
*.iopin en
XM1 READY in1 VSS VSS sg13_lv_nmos w=.15u l=0.13u ng=1 m=1
XM2 READY vx_n VDD VDD sg13_lv_pmos w=2u l=0.13u ng=1 m=1
XM4 vx net1 net5 VDD sg13_lv_pmos w=1u l=0.13u ng=1 m=1
x46 net1 vxs READY VDD VSS sg13g2_or2_2
x6 vx_n vxs VDD VSS sg13g2_inv_2
XM3 READY in2 VSS VSS sg13_lv_nmos w=.15u l=0.13u ng=1 m=1
XM5 vx READY VSS VSS sg13_lv_nmos w=1u l=0.13u ng=1 m=1
XM7 net5 VTUNE VDD VDD sg13_lv_pmos w=1u l=5u ng=1 m=1
XM6 net4 vx VDD VDD sg13_lv_pmos w=0.15u l=0.13u ng=1 m=1
XM8 net3 vx net2 VSS sg13_lv_nmos w=0.15u l=0.13u ng=1 m=1
XM9 net3 vx net4 VDD sg13_lv_pmos w=0.15u l=0.13u ng=1 m=1
XM10 net2 vx VSS VSS sg13_lv_nmos w=0.15u l=0.13u ng=1 m=1
XM11 VDD net3 net2 VDD sg13_lv_nmos w=0.15u l=0.13u ng=1 m=1
XM12 VSS net3 net4 VSS sg13_lv_pmos w=0.15u l=0.13u ng=1 m=1
x1 vxs net3 VDD VSS sg13g2_inv_2
x2 PULSE_n net1 en VDD VSS sg13g2_and2_2
XM13 READY en VDD VDD sg13_lv_pmos w=2u l=0.13u ng=1 m=1
.ends

* expanding   symbol:  comparator/discrete_time/Dynamic-biasing/dynamic_biasing_comparator.sym # of pins=8
** sym_path: /foss/designs/SAR_ADC_IHP/xschem/comparator/discrete_time/Dynamic-biasing/dynamic_biasing_comparator.sym
** sch_path: /foss/designs/SAR_ADC_IHP/xschem/comparator/discrete_time/Dynamic-biasing/dynamic_biasing_comparator.sch
.subckt dynamic_biasing_comparator di_clk_n di_clk VDD voutp vinp VSS voutn vinn
*.iopin VDD
*.opin voutp
*.opin voutn
*.ipin di_clk_n
*.iopin VSS
*.ipin vinp
*.ipin vinn
*.ipin di_clk
XM3a vs di_clk vctail VSS sg13_lv_nmos w=4.0u l=0.13u ng=1 m=1
XM12 voutp di_clk_n VSS VSS sg13_lv_nmos w=4.0u l=0.13u ng=1 m=1
XM8 net1 voutn VDD VDD sg13_lv_pmos w=8.0u l=0.13u ng=2 m=1
XM10 voutp voutn VSS VSS sg13_lv_nmos w=4.0u l=0.13u ng=1 m=1
XM11 voutn voutp VSS VSS sg13_lv_nmos w=4.0u l=0.13u ng=1 m=1
XM13 voutn di_clk_n VSS VSS sg13_lv_nmos w=4.0u l=0.13u ng=1 m=1
CPn vcpn VSS 80f m=1
CPp vcpp VSS 80f m=1
XM9 net2 voutp VDD VDD sg13_lv_pmos w=8.0u l=0.13u ng=2 m=1
XM6 voutp vcpn net1 VDD sg13_lv_pmos w=10.0u l=0.13u ng=2 m=1
XM7 voutn vcpp net2 VDD sg13_lv_pmos w=10.0u l=0.13u ng=2 m=1
CTAIL vctail VSS 600f m=1
XM3b vctail di_clk_n VSS VSS sg13_lv_nmos w=2.0u l=0.13u ng=1 m=1
XM1 vcpn vinp vs VSS sg13_lv_nmos w=6.0u l=0.13u ng=1 m=1
XM2 vcpp vinn vs VSS sg13_lv_nmos w=6.0u l=0.13u ng=1 m=1
XM4 vcpn di_clk VDD VDD sg13_lv_pmos w=2.0u l=0.13u ng=1 m=1
XM5 vcpp di_clk VDD VDD sg13_lv_pmos w=2.0u l=0.13u ng=1 m=1
.ends

* expanding   symbol:  dac_icms_cell/unit_cell_n.sym # of pins=11
** sym_path: /foss/designs/SAR_ADC_IHP/xschem/dac_icms_cell/unit_cell_n.sym
** sch_path: /foss/designs/SAR_ADC_IHP/xschem/dac_icms_cell/unit_cell_n.sch
.subckt unit_cell_n VDD d VSS v_top bit v_cm v_in a_sample a_sample_n b_sample b_sample_n  W_P_SPDT=1.0u L_P_SPDT=0.13u
+ W_N_SPDT=1.0u L_N_SPDT=0.13u Cu=8f n=1
*.iopin VSS
*.iopin v_in
*.iopin VDD
*.ipin d
*.ipin bit
*.iopin v_top
*.iopin v_cm
*.ipin a_sample
*.ipin a_sample_n
*.ipin b_sample
*.ipin b_sample_n
x1 VDD d VSS net1 bit v_cm v_in b_sample_n b_sample dac_switch_n W_P_TG=3.0u L_P_TG=0.13u W_N_TG=1.0u L_N_TG=0.13u n=n
x2 VDD a_sample VSS v_cm v_top a_sample_n transmission_gate_lv_w_dummy W_P=W_P_SPDT L_P=L_P_SPDT W_N=W_N_SPDT L_N=L_N_SPDT
+ W_P_D=1.0u L_P_D=0.13u W_N_D=1.0u L_N_D=0.13u n=n
XC1 net1 v_top cap_cmim w=2.6e-6 l=2.6e-6 m=n
.ends

* expanding   symbol:  dac_icms_cell/unit_cell.sym # of pins=11
** sym_path: /foss/designs/SAR_ADC_IHP/xschem/dac_icms_cell/unit_cell.sym
** sch_path: /foss/designs/SAR_ADC_IHP/xschem/dac_icms_cell/unit_cell.sch
.subckt unit_cell VDD d VSS v_top bit v_cm v_in a_sample a_sample_n b_sample b_sample_n  W_P_SPDT=1.0u L_P_SPDT=0.13u
+ W_N_SPDT=1.0u L_N_SPDT=0.13u Cu=8f n=1
*.iopin VSS
*.iopin v_in
*.iopin VDD
*.ipin d
*.ipin bit
*.iopin v_top
*.iopin v_cm
*.ipin a_sample_n
*.ipin a_sample
*.ipin b_sample
*.ipin b_sample_n
x1 VDD d VSS net1 bit v_cm v_in b_sample_n b_sample dac_switch W_P_TG=3.0u L_P_TG=0.13u W_N_TG=1.0u L_N_TG=0.13u n=n
x2 VDD a_sample_n VSS v_cm v_top a_sample transmission_gate_lv_w_dummy W_P=W_P_SPDT L_P=L_P_SPDT W_N=W_N_SPDT L_N=L_N_SPDT
+ W_P_D=1.0u L_P_D=0.13u W_N_D=1.0u L_N_D=0.13u n=n
XC1 net1 v_top cap_cmim w=2.6e-6 l=2.6e-6 m=n
.ends

* expanding   symbol:  logic/bit_cell.sym # of pins=8
** sym_path: /foss/designs/SAR_ADC_IHP/xschem/logic/bit_cell.sym
** sch_path: /foss/designs/SAR_ADC_IHP/xschem/logic/bit_cell.sch
.subckt bit_cell clk p_bit_dec reset comp_in VDD bit VSS dec
*.iopin p_bit_dec
*.iopin clk
*.iopin reset
*.iopin comp_in
*.iopin VDD
*.iopin VSS
*.iopin bit
*.iopin dec
x1 VDD net2 net4 VSS net5 net1 SR_latch W_P_SR=1.0u L_P_SR=0.13u W_N_SR=1.0u L_N_SR=0.13u
x23 net1 net6 n_dec VDD VSS sg13g2_and2_1
x14 net2 n_dec comp_in VDD VSS sg13g2_and2_1
x30 net6 comp_in VDD VSS sg13g2_inv_2
x53 net3 n_dec clk p_bit_dec reset VDD VSS sg13g2_dfrbp_1
* noconn #net4
x2 VDD net5 net7 VSS buffer_lv W_P_INV=3.0u L_P_INV=0.13u W_N_INV=1.0u L_N_INV=0.13u
x3 VDD net3 net8 VSS buffer_lv W_P_INV=3.0u L_P_INV=0.13u W_N_INV=1.0u L_N_INV=0.13u
x4 VDD net8 dec VSS buffer_lv W_P_INV=10.0u L_P_INV=0.13u W_N_INV=10.0u L_N_INV=0.13u
x5 VDD net7 bit VSS buffer_lv W_P_INV=10.0u L_P_INV=0.13u W_N_INV=10.0u L_N_INV=0.13u
.ends

* expanding   symbol:  comparator/NOR_gate/NOR_gate.sym # of pins=5
** sym_path: /foss/designs/SAR_ADC_IHP/xschem/comparator/NOR_gate/NOR_gate.sym
** sch_path: /foss/designs/SAR_ADC_IHP/xschem/comparator/NOR_gate/NOR_gate.sch
.subckt NOR_gate VDD C A B VSS  W_P=1.0u L_P=0.13u W_N=0.5u L_N=0.13u
*.iopin VDD
*.opin C
*.iopin VSS
*.ipin A
*.ipin B
XM1 C A VSS VSS sg13_lv_nmos w=W_N l=L_N ng=1 m=1
XM2 C B VSS VSS sg13_lv_nmos w=W_N l=L_N ng=1 m=1
XM3 C B net1 VDD sg13_lv_pmos w=W_P l=L_P ng=1 m=1
XM4 net1 A VDD VDD sg13_lv_pmos w=W_P l=L_P ng=1 m=1
XM5 C A net2 VDD sg13_lv_pmos w=W_P l=L_P ng=1 m=1
XM6 net2 B VDD VDD sg13_lv_pmos w=W_P l=L_P ng=1 m=1
.ends

* expanding   symbol:  dac_icms_cell/dac_switch_n.sym # of pins=9
** sym_path: /foss/designs/SAR_ADC_IHP/xschem/dac_icms_cell/dac_switch_n.sym
** sch_path: /foss/designs/SAR_ADC_IHP/xschem/dac_icms_cell/dac_switch_n.sch
.subckt dac_switch_n VDD d VSS v_cap bit v_cm v_in sample sample_n  W_P_TG=3.0u L_P_TG=0.13u W_N_TG=1.0u L_N_TG=0.13u n=1
*.iopin v_in
*.iopin v_cap
*.iopin VDD
*.iopin VSS
*.ipin d
*.iopin v_cm
*.ipin bit
*.ipin sample
*.ipin sample_n
x8 VDD d d_n VSS inverter_lv W_P=W_P_TG L_P=L_P_TG W_N=W_N_TG L_N=L_N_TG n=n
XM1 v_cap net3 VSS VSS sg13_lv_nmos w=1u l=0.2u ng=1 m=n
XM3 v_cap net4 VDD VDD sg13_lv_pmos w=1.2u l=0.13u ng=1 m=n
x2 VDD net2 VSS v_cap v_cm net1 transmission_gate_lv_w_dummy W_P=W_P_TG L_P=L_P_TG W_N=W_N_TG L_N=L_N_TG W_P_D=1.0u L_P_D=0.13u
+ W_N_D=1.0u L_N_D=0.13u n=n
x1 VDD sample VSS v_cap v_in sample_n transmission_gate_lv_w_dummy W_P=W_P_TG L_P=L_P_TG W_N=W_N_TG L_N=L_N_TG W_P_D=1.0u
+ L_P_D=0.13u W_N_D=1.0u L_N_D=0.13u n=n
x23 net5 bit d VDD VSS sg13g2_nand2_1
x46 net6 net9 d VDD VSS sg13g2_and2_1
x4 VDD net5 net4 VSS buffer_lv W_P_INV=3.0u L_P_INV=0.13u W_N_INV=1.0u L_N_INV=0.13u
x5 VDD net6 net3 VSS buffer_lv W_P_INV=3.0u L_P_INV=0.13u W_N_INV=1.0u L_N_INV=0.13u
x3 net7 d sample VDD VSS sg13g2_nor2_1
x6 net8 d sample VDD VSS sg13g2_or2_1
x7 VDD net7 net2 VSS buffer_lv W_P_INV=3.0u L_P_INV=0.13u W_N_INV=1.0u L_N_INV=0.13u
x9 VDD net8 net1 VSS buffer_lv W_P_INV=3.0u L_P_INV=0.13u W_N_INV=1.0u L_N_INV=0.13u
x32 net9 bit VDD VSS sg13g2_inv_1
.ends

* expanding   symbol:  transmission_gate/transmission_gate_lv_w_dummy.sym # of pins=6
** sym_path: /foss/designs/SAR_ADC_IHP/xschem/transmission_gate/transmission_gate_lv_w_dummy.sym
** sch_path: /foss/designs/SAR_ADC_IHP/xschem/transmission_gate/transmission_gate_lv_w_dummy.sch
.subckt transmission_gate_lv_w_dummy VDD di_tg_ctrl VSS v_b v_a di_tg_ctrl_n  W_P=2.0u L_P=0.13u W_N=2.0u L_N=0.13u W_P_D=1.0u
+ L_P_D=0.13u W_N_D=1.0u L_N_D=0.13u n=1
*.iopin v_a
*.iopin v_b
*.iopin VDD
*.iopin VSS
*.ipin di_tg_ctrl
*.ipin di_tg_ctrl_n
XM1 net3 net5 net4 VSS sg13_lv_nmos w=W_N l=L_N ng=1 m=n
XM2 net2 net6 net1 VDD sg13_lv_pmos w=W_P l=L_P ng=1 m=n
XMdummy2 net1 net7 net1 VDD sg13_lv_pmos w=W_P l=L_P ng=1 m={n/2}
XMdummy1 net4 net8 net4 VSS sg13_lv_nmos w=W_N l=L_N ng=1 m={n/2}
Vig1 di_tg_ctrl net5 0
Vig2 di_tg_ctrl_n net6 0
Vig1d di_tg_ctrl_n net8 0
Vig2d di_tg_ctrl net7 0
Vid2 v_a net2 0
Vid1 v_a net3 0
Vis2 v_b net1 0
Vis1 v_b net4 0
.ends

* expanding   symbol:  dac_icms_cell/dac_switch.sym # of pins=9
** sym_path: /foss/designs/SAR_ADC_IHP/xschem/dac_icms_cell/dac_switch.sym
** sch_path: /foss/designs/SAR_ADC_IHP/xschem/dac_icms_cell/dac_switch.sch
.subckt dac_switch VDD d VSS v_cap bit v_cm v_in sample sample_n  W_P_TG=3.0u L_P_TG=0.13u W_N_TG=1.0u L_N_TG=0.13u n=1
*.iopin v_in
*.iopin v_cap
*.iopin VDD
*.iopin VSS
*.ipin d
*.ipin bit
*.ipin sample
*.ipin sample_n
*.iopin v_cm
x8 VDD d d_n VSS inverter_lv W_P=W_P_TG L_P=L_P_TG W_N=W_N_TG L_N=L_N_TG n=n
XM1 v_cap net1 VSS VSS sg13_lv_nmos w=1u l=0.13u ng=1 m=n
XM3 v_cap net2 VDD VDD sg13_lv_pmos w=1.2u l=0.2u ng=1 m=n
x1 VDD sample VSS v_cap v_in sample_n transmission_gate_lv_w_dummy W_P=W_P_TG L_P=L_P_TG W_N=W_N_TG L_N=L_N_TG W_P_D=1.0u
+ L_P_D=0.13u W_N_D=1.0u L_N_D=0.13u n=n
x23 net3 net9 d VDD VSS sg13g2_nand2_1
x46 net4 bit d VDD VSS sg13g2_and2_1
x4 VDD net3 net2 VSS buffer_lv W_P_INV=3.0u L_P_INV=0.13u W_N_INV=1.0u L_N_INV=0.13u
x5 VDD net4 net1 VSS buffer_lv W_P_INV=3.0u L_P_INV=0.13u W_N_INV=1.0u L_N_INV=0.13u
x32 net9 bit VDD VSS sg13g2_inv_1
x3 VDD net6 VSS v_cap v_cm net5 transmission_gate_lv_w_dummy W_P=W_P_TG L_P=L_P_TG W_N=W_N_TG L_N=L_N_TG W_P_D=1.0u L_P_D=0.13u
+ W_N_D=1.0u L_N_D=0.13u n=n
x6 net7 d sample VDD VSS sg13g2_nor2_1
x7 net8 d sample VDD VSS sg13g2_or2_1
x9 VDD net7 net6 VSS buffer_lv W_P_INV=3.0u L_P_INV=0.13u W_N_INV=1.0u L_N_INV=0.13u
x10 VDD net8 net5 VSS buffer_lv W_P_INV=3.0u L_P_INV=0.13u W_N_INV=1.0u L_N_INV=0.13u
.ends

.GLOBAL GND
.end
