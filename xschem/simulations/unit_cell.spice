** sch_path: /foss/designs/SAR_ADC_IHP/xschem/dac_icms_cell/unit_cell.sch
**.subckt unit_cell VDD d VSS v_top bit v_cm v_in a_sample a_sample_n b_sample b_sample_n
*.iopin VSS
*.iopin v_in
*.ipin d
*.ipin bit
*.iopin v_top
*.iopin v_cm
*.ipin a_sample
*.ipin a_sample_n
*.ipin b_sample
*.ipin b_sample_n
*.iopin VDD
S1 net2 net1 d VSS SW1
C2 net1 v_top cu m=32
S2 v_cm net1 a_sample_n a_sample SW1
S3 v_in net1 a_sample a_sample_n SW1
S4 v_top v_cm b_sample b_sample_n SW1
S5 VDD net2 bit VSS SW1
S6 net2 VSS VSS bit SW1
**.ends
**** begin user architecture code
.MODEL SW1 SW
+ VT=0.9 VH=0.01
+ RON=0.01 ROFF=10G
**** end user architecture code
.end
