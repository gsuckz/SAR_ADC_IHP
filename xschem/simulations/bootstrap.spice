** sch_path: /foss/designs/SAR_ADC_IHP/xschem/bootstrap/bootstrap.sch
**.subckt bootstrap VSS IN OUT close close_n VDD
*.iopin VDD
*.iopin VSS
*.iopin IN
*.iopin OUT
*.iopin close
*.iopin close_n
*.iopin VDD_H
XM6 vgate close_n2 vbootstrap vbootstrap sg13_hv_pmos w=10u l=0.4u ng=5 m=5
XM8 close_n2 close Y VSS sg13_hv_nmos w=5u l=0.45u ng=1 m=5
XM9 close_n2 close VDD VDD sg13_hv_pmos w=15u l=0.4u ng=5 m=5
XM10 close_n2 vgate Y VSS sg13_hv_nmos w=5u l=0.45u ng=1 m=5
XM11 Y vgate IN VSS sg13_hv_nmos w=5u l=0.45u ng=10 m=1
C3 vbootstrap Y 2p m=1
XM12 Y close_n VSS VSS sg13_hv_nmos w=10u l=0.45u ng=1 m=2
XM13 vgate VDD vgate_ground VSS sg13_hv_nmos w=7u l=0.45u ng=2 m=4
XM3 vgate_ground close_n VSS VSS sg13_hv_nmos w=7u l=0.45u ng=2 m=4
XM1 OUT vgate IN VSS sg13_hv_nmos w=0.6u l=0.45u ng=2 m=64
XM2 VDD vpump vbootstrap VSS sg13_hv_nmos w=10u l=0.45u ng=1 m=2
XM15 net1 close_n VSS VSS sg13_hv_nmos w=10u l=0.45u ng=1 m=2
XM7 net2 close VSS VSS sg13_hv_nmos w=10u l=0.45u ng=1 m=2
XM4 net2 net1 VDD_H VSS sg13_hv_pmos w=15u l=0.4u ng=5 m=5
XM5 net1 net2 VDD_H VSS sg13_hv_pmos w=15u l=0.4u ng=5 m=5
XM14 net3 net2 VDD_H VDD_H sg13_hv_pmos w=15u l=0.4u ng=5 m=5
XM16 net3 net2 VSS VSS sg13_hv_nmos w=10u l=0.45u ng=1 m=2
**.ends
.end
