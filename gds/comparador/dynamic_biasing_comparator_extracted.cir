* Extracted by KLayout with SG13G2 LVS runset on : 19/11/2025 21:52

.SUBCKT dynamic_biasing_comparator 3 4 5 6 10 11 12 13 14 15 16
M$1 2 4 5 1 sg13_lv_nmos L=0.13u W=2u AS=0.53p AD=0.53p PS=4.06u PD=4.06u
M$3 2 3 5 1 sg13_lv_nmos L=0.13u W=2u AS=0.53p AD=0.53p PS=4.06u PD=4.06u
M$5 2 3 4 1 sg13_lv_nmos L=0.13u W=2u AS=0.53p AD=0.53p PS=4.06u PD=4.06u
M$7 2 5 4 1 sg13_lv_nmos L=0.13u W=2u AS=0.53p AD=0.53p PS=4.06u PD=4.06u
M$9 12 3 2 1 sg13_lv_nmos L=0.13u W=2u AS=0.53p AD=0.53p PS=4.06u PD=4.06u
M$11 14 13 12 1 sg13_lv_nmos L=0.13u W=16u AS=3.34p AD=3.34p PS=21.34u PD=21.34u
M$19 10 15 14 1 sg13_lv_nmos L=0.13u W=5u AS=1.1p AD=1.1p PS=8.2u PD=8.2u
M$24 14 16 11 1 sg13_lv_nmos L=0.13u W=5u AS=1.1p AD=1.1p PS=8.2u PD=8.2u
M$29 9 11 5 7 sg13_lv_pmos L=0.13u W=6u AS=1.365p AD=1.365p PS=9.32u PD=9.32u
M$33 8 10 4 7 sg13_lv_pmos L=0.13u W=6u AS=1.365p AD=1.365p PS=9.32u PD=9.32u
M$37 9 4 6 7 sg13_lv_pmos L=0.13u W=4u AS=0.91p AD=0.91p PS=6.82u PD=6.82u
M$41 8 5 6 7 sg13_lv_pmos L=0.13u W=4u AS=0.91p AD=0.91p PS=6.82u PD=6.82u
M$45 6 13 10 17 sg13_lv_pmos L=0.13u W=3u AS=0.72p AD=0.72p PS=5.44u PD=5.44u
M$48 11 13 6 17 sg13_lv_pmos L=0.13u W=3u AS=0.72p AD=0.72p PS=5.44u PD=5.44u
C$51 2 11 cap_cmim w=7u l=7u A=49p P=28u m=1
C$52 2 10 cap_cmim w=7u l=7u A=49p P=28u m=1
C$53 2 12 cap_cmim w=20u l=20u A=400p P=80u m=1
R$54 7 6 ntap1 A=13.7928p P=90.08u
R$58 17 6 ntap1 A=1.2168p P=6.24u
R$60 1 2 ptap1 A=16.4328p P=98.32u
.ENDS dynamic_biasing_comparator
